* filters_ac.cir - small-signal responses of the JACON filters / amplifiers
* (generated by build_jacon.py)  plot V(*_out) in dB
.param TEST=-1 TSTOP=1
.param F_RADAR=9.4e9
.param P_RADAR=-30
.param T_PULSE_ON=20n
.param PW_RADAR=150n
.param T_RISE=1n
.param P1_START=-60
.param P1_STOP=20
.param LIM_PMAX=17
.param LIM_IL=0.5
.param ATT_RX=0
.param LNA_G=22
.param LNA_P1DB=17
.param F_LO=8.3e9
.param P_PLL=3
.param LOBUF_G=12
.param LOBUF_P1DB=14
.param LOSPLIT_IL=0.7
.param MIX_CL=6.7
.param MIX_LO_NOM=10
.param MIX_IFBW=4e9
.param MIX_LOIF_ISO=25
.param MIX_LORF_ISO=30
.param IFA_G=22.5
.param IFA_P1DB=18
.param IFA_FHP=300e6
.param IFA_FLP=2.5e9
.param F_IF_NOM=1.1e9
.param ENV_BW=130e6
.param ENV_K=1
.param ENV_OFS=0
.param VTH_DAC=15m
.param COMP_VOD=0.5m
.param COMP_TPD=3.5n
.param LIMA_G=17
.param LIMA_P1DB=12
.param LIMA_FLP=1.6e9
.param VF=0.70
.param L_REF_IN=6
.param DL_IN=4.5
.param COAX_DB_FT=0.4
.param MIXMODE=1
.param PD_CL=6
.param PD_LO_NOM=7
.param PD_FLP=100e6
.param SH_DLY=40n
.param SH_WIDTH=40n
.param SH_RON=120
.param SH_ROFF=1G
.param SH_C=100p
.param PD_V0=-0.3372
.param OPA_GAIN=19.46
.param VT_CENTER=7.75
.param OPA_VMIN=0
.param OPA_VMAX=11.5
.param OPA_GBW=8e6
.param VCO_V1=6
.param VCO_F1=1.0e9
.param VCO_V2=9.5
.param VCO_F2=1.2e9
.param VCO_FMIN=0.8e9
.param VCO_FMAX=1.6e9
.param P_VCO=3
.param MORSE_UNIT=60n
.param MORSE_HOLDOFF=1.6u
.param KEY_TR=2n
.param KEY_ISO=40
.param KEY_IL=1
.param IRF_FC=8.2e9
.param IRF_IL=1.0
.param PA_G=30
.param PA_P1DB=30
.param F_IF_TEST=1.1e9
.param P4_START=-35
.param P4_STEP=10
.param T4_PER=150n
.param T4_PW=60n
.param P5_START=-50
.param P5_STOP=5
.param P6=-20
.param F6_START=1.0e9
.param F6_STEP=10e6
.param T6_STEP=8n
.param T7_PER=1u
.param T7_PW=100n
.param T7_DV=0.05
.param VT8_START=5
.param VT8_STOP=10.5
.include jacon_blocks.inc

* image-reject high-pass (TX)
V1 s1 0 AC 2
R1 s1 a1 50
X_IRF a1 irf_out IMG_REJ
R_IRF irf_out 0 50

* RX mixer IF port low-pass (LPF3 @ MIX_IFBW)
V2 s2 0 AC 2
R2 s2 a2 50
X_L2 a2 mixif_out LPF3 FC={MIX_IFBW}
R_L2 mixif_out 0 50

* phase detector low-pass
V3 s3 0 AC 2
R3 s3 a3 50
X_L3 a3 pdlpf_out LPF3 FC={PD_FLP}
R_L3 pdlpf_out 0 50

* limiter harmonic low-pass
V4 s4 0 AC 2
R4 s4 a4 50
X_L4 a4 limlpf_out LPF3 FC={LIMA_FLP}
R_L4 limlpf_out 0 50

* IF amplifier (small signal)
V5 s5 0 AC 2
R5 s5 a5 50
X_IFA a5 ifamp_out IF_AMP
R_IFA ifamp_out 0 50

.ac dec 400 10e6 20e9
.end
