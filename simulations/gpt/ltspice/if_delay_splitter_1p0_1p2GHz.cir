* Focused LTspice simulation: 1.0-1.2 GHz enters a wire, reaches a 50 ohm
* splitter, then two cable lengths. One cable can be 4.5 inches longer.
*
* At the cable ends the two signals are multiplied. A low-pass removes f0+f1,
* leaving a DC/baseband term proportional to cos(2*pi*f*delta_t).
*
* Switchable delay cases:
*   DELAY_MODE=0 -> physical 4.5 inch extra coax at VF=0.66
*   DELAY_MODE=1 -> quadrature target at 1.1 GHz, delta_t=1/(4*1.1 GHz)
*
* Recommended plots:
*   V(if_src)      input sine at the wire
*   V(split)       splitter input node
*   V(out_a)       direct cable end
*   V(out_b)       delayed cable end
*   V(mix_raw)     product with f0+f1 ripple
*   V(mix_lpf)     low-pass result, proportional to cos(2*pi*f*delta_t)

.include jacon_common_models.lib

.param fin=1.1G
.param amp=0.2236
.param coax_vf=0.66
.param feed_len_in=2
.param base_len_in=12
.param extra_len_in=4.5
.param DELAY_MODE=0
.param td_feed={feed_len_in*0.0254/(coax_vf*c0)}
.param td_base={base_len_in*0.0254/(coax_vf*c0)}
.param td_4p5in={extra_len_in*0.0254/(coax_vf*c0)}
.param td_quad={1/(4*1.1G)}
.param td_extra={if(DELAY_MODE==0, td_4p5in, td_quad)}

* SECTION A: 50 ohm source and feed wire into splitter
Vif if_src 0 SINE(0 {amp} {fin})
Rsrc if_src feed_in 50
Tfeed feed_in 0 split 0 Z0=50 TD={td_feed}

* SECTION B: idealized equal splitter into two coax runs
* The resistors make this easy to modify when replacing with a real splitter
* S-parameter model later.
Rsplit_a split a_in 16.7
Rsplit_b split b_in 16.7
Rsplit_iso a_in b_in 100
Tdirect a_in 0 out_a 0 Z0=50 TD={td_base}
Tdelayed b_in 0 out_b 0 Z0=50 TD={td_base+td_extra}
Rload_a out_a 0 50
Rload_b out_b 0 50

* SECTION C: passive mixer / multiplier and low-pass recovery of cos term
Xmult out_a out_b mix_raw ideal_multiplier PARAMS: scale=1
Rmix mix_raw mix_lpf 1k
Clpf mix_lpf 0 15.9p
Rdc mix_lpf 0 1Meg

.save V(if_src) V(split) V(out_a) V(out_b) V(mix_raw) V(mix_lpf)
.step param fin list 1.0G 1.05G 1.1G 1.15G 1.2G
.step param DELAY_MODE list 0 1
.tran 0 30n 0 0.5p
.options plotwinsize=0 numdgt=7
.meas tran mix_lpf_avg AVG V(mix_lpf) FROM=24n TO=30n
.meas tran a_rms RMS V(out_a) FROM=24n TO=30n
.meas tran b_rms RMS V(out_b) FROM=24n TO=30n
.end
